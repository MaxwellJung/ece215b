ADE simulation setup
Run mode: Single Run, Sweeps and Corners
Tests:
  final_project_3X8_Decoder_1: final_project/3X8_Decoder/schematic, simulator spectre
    Variables: i1 = 0; i1_b = 1; i2 = 0; i2_b = 1; i3 = 1; i3_b = 0
