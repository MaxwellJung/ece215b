ADE simulation setup
Test eDRAMLib_eDRAM_test_1: eDRAMLib/eDRAM_test/schematic, simulator spectre
  Models: /w/apps4/public_libraries/tech/cadence/cadence/45nm/gpdk045_v_3_5/gpdk045/../models/spectre/gpdk045.scs[tt]
  Variables: aB0 = 255; aB1 = 1; dB0 = 10; dB1 = 10; dB2 = 10; dB3 = 10; t = 2n
  Temperature: 27
  Analysis tran: stop=5n errpreset=liberal
  Signals: /Addr<8:0>, /I0/Col3, /I0/Col2, /I0/Col1, /I0/Col0, /I0/WL<127:0>, /WriteEn, /I0/wbl<31:0>, /ReadEn, /I0/rbl<31:0>, /I0/rbl_b<31:0>, /I0/AmpEn, /I0/amp_out<31:0>, /I0/amp_out_b<31:0>, /DQ<31:0>
Test eDRAMLib_eDRAM_simple_test: eDRAMLib/eDRAM_simple_test/schematic, simulator spectre
  Models: /w/apps4/public_libraries/tech/cadence/cadence/45nm/gpdk045_v_3_5/gpdk045/../models/spectre/gpdk045.scs[tt]
  Variables: aB0 = 255; aB1 = 1; dB0 = 10; dB1 = 10; dB2 = 10; dB3 = 10; t = 2n
  Temperature: 25.0
  Analysis tran: stop=12n errpreset=moderate
  Signals: /Addr<8:0>, /WriteEn, /ReadEn, /I0/rbl0<31:0>, /I0/rbl_b0<31:0>, /I0/rbl0_r127<31:0>, /I0/rbl<31:0>, /I0/rbl_b0_r127<31:0>, /I0/rbl_b<31:0>, /I0/AmpEn, /I0/amp_out<7:0>, /I0/amp_out_b<7:0>, /DQ<7:0>, /I0/I25/net4, /I0/I25/wbl0<7:0>, /I0/rbl0<7:0>, /I0/rbl_b0<7:0>
