ADE simulation setup
Test eDRAMLib_eDRAM_test_1: eDRAMLib/eDRAM_test/schematic, simulator spectre
  Models: /w/apps4/public_libraries/tech/cadence/cadence/45nm/gpdk045_v_3_5/gpdk045/../models/spectre/gpdk045.scs[tt]
  Variables: aB0 = 255; aB1 = 1; dB0 = 10; dB1 = 10; dB2 = 10; dB3 = 10; t = 2n
  Temperature: 27
  Analysis tran: stop=5n errpreset=liberal
  Signals: /Addr<8:0>, /I0/Col3, /I0/Col2, /I0/Col1, /I0/Col0, /I0/WL<127:0>, /WriteEn, /I0/wbl<31:0>, /ReadEn, /I0/rbl<31:0>, /I0/rbl_b<31:0>, /I0/AmpEn, /I0/amp_out<31:0>, /I0/amp_out_b<31:0>, /DQ<31:0>
Test eDRAMLib_eDRAM_simple_test: eDRAMLib/eDRAM_simple_test/schematic, simulator spectre
  Models: /w/apps4/public_libraries/tech/cadence/cadence/45nm/gpdk045_v_3_5/gpdk045/../models/spectre/gpdk045.scs[tt]
  Variables: aB0 = 0; aB1 = 0; dB0 = 255; dB1 = 255; dB2 = 255; dB3 = 255; t = 2n
  Temperature: 25.0
  Analysis tran: stop=16n errpreset=moderate
  Output Energy_W = integ((VT("/vdd_OP") * IT("/DummyVDD/MINUS")) 0 2e-09 " ") (unticked)
  Output Energy_R = integ((VT("/vdd_OP") * IT("/DummyVDD/MINUS")) 2e-09 4e-09 " ") (unticked)
  Signals: /Addr<8:0>, /WriteEn, /testWord<31:0>, /ReadEn, /DQ<7:0>, /vdd_OP, /DummyVDD/MINUS (terminal), /I0/I84/I9/I0<31:0>/sn
