ADE simulation setup
Run mode: Single Run, Sweeps and Corners
Tests:
  eDRAMLib_eDRAM_simple_test: eDRAMLib/eDRAM_simple_test/schematic, simulator spectre
    Variables: aB0 = 0; aB1 = 0; dB0 = 255; dB1 = 255; dB2 = 255; dB3 = 255; t = 2n
    Outputs: "/I0/amp_out<31:0>"; /I0/WL<127:0>; "/I0/amp_out_b<31>"; "/I0/amp_out<7:0>"; "/I0/amp_out<3>"; "/X"; /X; "/I0/amp_out_b<0>"; "/I0/amp_out_b<31:0>"; "/I0/amp_out<31>"; "/I0/amp_out_b<7:0>"; "/I0/wbl_r64_0<31:0>"; /I0/wbl_r64_1<0:31>; "/I0/wbl_r64_1<7:0>"; "/I0/wbl_r64_0<7:0>"; /I0/wbl<7:0>; /I0/amp_out<7:0>; /I0/amp_out_b<7:0>; /DQ<7:0>; IDC("/V0/PLUS"); nil; Energy_W; Energy_R; /I0/I84/I9/I0<31:0>/sn
