ADE simulation setup
Test final_project_4X16_Decoder_1: eDRAMLib/4X16_Decoder/schematic, simulator spectre
  Models: /w/apps4/public_libraries/tech/cadence/cadence/45nm/gpdk045_v_3_5/gpdk045/../models/spectre/gpdk045.scs[mc]
  Variables: i0 = 1; i0_b = 0; i1 = 1; i1_b = 0; i2 = 0; i2_b = 1; i3 = 1; i3_b = 0
  Temperature: 27
  Analysis tran: stop=10n errpreset=conservative
  Signals: /S_I0, /S_I1, /S_I2, /S_I3, /S_Y0, /S_Y1, /S_Y2, /S_Y3, /S_Y4, /S_Y5, /S_Y6, /S_Y7, /S_Y8, /S_Y9, /S_Y10, /S_Y11, /S_Y12, /S_Y13, /S_Y14, /S_Y15
Run mode: Single Run, Sweeps and Corners
