ADE simulation setup
Test eDRAMLib_tristate_buffer_test_1: eDRAMLib/tristate_buffer_test/schematic, simulator spectre
  Models: /w/apps4/public_libraries/tech/cadence/cadence/45nm/gpdk045_v_3_5/gpdk045/../models/spectre/gpdk045.scs[mc]
  Variables: dB0 = 0; dB1 = 255; dB2 = 0; dB3 = 255; t = 2n
  Temperature: 27
  Analysis tran: stop=10n errpreset=conservative
  Signals: /WriteEn, /testWord<31:0>, /DQ<31:0>, /I16/tristate_buffer_32<31>/net1
Run mode: Single Run, Sweeps and Corners
