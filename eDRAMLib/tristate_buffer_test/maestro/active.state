ADE simulation setup
Test eDRAMLib_tristate_buffer_test_1: eDRAMLib/tristate_buffer_test/schematic, simulator spectre
  Models: /w/apps4/public_libraries/tech/cadence/cadence/45nm/gpdk045_v_3_5/gpdk045/../models/spectre/gpdk045.scs[mc]
  Variables: t = 2n; B0 = 0; B1 = 0; B2 = 0; B3 = 0
  Temperature: 27
  Analysis tran: stop=10n errpreset=conservative
  Signals: /en, /in<31:0>, /out<31:0>
Run mode: Single Run, Sweeps and Corners
Setup values for test eDRAMLib_tristate_buffer_test_1: dB0 = 0; dB1 = 255; dB2 = 0; dB3 = 255
