ADE simulation setup
Run mode: Single Run, Sweeps and Corners
Tests:
  eDRAMLib_tristate_buffer_test_1: eDRAMLib/tristate_buffer_test/schematic, simulator spectre
    Outputs: "/en"; /en; /out<31:0>; /wbl<31:0>
