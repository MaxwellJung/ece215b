ADE simulation setup
Run mode: Single Run, Sweeps and Corners
Tests:
  eDRAMLib_tristate_buffer_test_1: eDRAMLib/tristate_buffer_test/schematic, simulator spectre
    Variables: B0 = 0; B1 = 0; B2 = 0; B3 = 0; t = 2n
    Outputs: "/en"; /en; /out<31:0>
