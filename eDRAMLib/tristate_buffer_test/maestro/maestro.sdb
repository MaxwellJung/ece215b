ADE simulation setup
Run mode: Single Run, Sweeps and Corners
Tests:
  eDRAMLib_tristate_buffer_test_1: eDRAMLib/tristate_buffer_test/schematic, simulator spectre
    Variables: dB0 = 0; dB1 = 255; dB2 = 0; dB3 = 255; t = 2n
    Outputs: "/en"; /WriteEn
