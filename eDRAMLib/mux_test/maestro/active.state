ADE simulation setup
Test final_mux_test_1: eDRAMLib/mux_test/schematic, simulator spectre
  Models: /w/apps4/public_libraries/tech/cadence/cadence/45nm/gpdk045_v_3_5/gpdk045/../models/spectre/gpdk045.scs[tt]
  Variables: x = 5n
  Temperature: 27
  Analysis tran: stop=20n errpreset=conservative
  Signals: /s1, /s0, /s1_b, /s0_b, /out<31:0>
Run mode: Single Run, Sweeps and Corners
