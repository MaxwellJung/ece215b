ADE simulation setup
Run mode: Single Run, Sweeps and Corners
Tests:
  final_mux_test_1: final/mux_test/schematic, simulator spectre
    Variables: x = 5n
