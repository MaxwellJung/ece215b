ADE simulation setup
Test eDRAMLib_sense_amp_1_test_1: eDRAMLib/sense_amp_1_test/schematic, simulator spectre
  Models: /w/apps4/public_libraries/tech/cadence/cadence/45nm/gpdk045_v_3_5/gpdk045/../models/spectre/gpdk045.scs[mc]
  Variables: midpoint = 840m; vd = 1; vdd = 1
  Temperature: 27
  Analysis tran: stop=20n errpreset=conservative
  Signals: /out_b, /out, /wbl, /rbl, /rwl, /wwl, /sense_en, /prechg, /rbl_p, /rbl_b
Run mode: Single Run, Sweeps and Corners
