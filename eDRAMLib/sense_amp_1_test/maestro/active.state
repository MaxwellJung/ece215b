ADE simulation setup
Test eDRAMLib_sense_amp_1_test_1: eDRAMLib/sense_amp_1_test/schematic, simulator spectre
  Models: /w/apps4/public_libraries/tech/cadence/cadence/45nm/gpdk045_v_3_5/gpdk045/../models/spectre/gpdk045.scs[mc]
  Variables: midpoint = 840m; vd = 1; vdd = 1
  Temperature: 25
  Analysis tran: stop=30n errpreset=conservative
  Signals: /out, /out_b, /rwl, /wwl, /wbl, /rbl_p, /rbl_b_p, /rbl, /rbl_b, /sense_en, /prechg
Run mode: Single Run, Sweeps and Corners
