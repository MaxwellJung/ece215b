ADE simulation setup
Run mode: Single Run, Sweeps and Corners
Tests:
  eDRAMLib_sense_amp_1_test_1: eDRAMLib/sense_amp_1_test/schematic, simulator spectre
    Variables: vd = 1; vdd = 1; midpoint = 840m
    Outputs: /out_b; /out; /wbl; /rbl; /rwl; /wwl; "/l"; "/sense_en"; /sense_en; /prechg; /rbl_p; /rbl_b
