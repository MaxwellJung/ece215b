ADE simulation setup
Test eDRAMLib_3T_cell_test_1: eDRAMLib/3T_cell_test/schematic, simulator spectre
  Models: /w/apps4/public_libraries/tech/cadence/cadence/45nm/gpdk045_v_3_5/gpdk045/../models/spectre/gpdk045.scs[tt]
  Variables: t = 5n
  Temperature: 27
  Analysis tran: stop=30n errpreset=conservative
  Signals: /wwl, /rwl, /wbl, /rbl, /I0/net5
Run mode: Single Run, Sweeps and Corners
Setup values for test eDRAMLib_3T_cell_test_1: t = 2n; B0 = 0xEF; B1 = 0xBE; B2 = 0xAD; B3 = 0xDE
