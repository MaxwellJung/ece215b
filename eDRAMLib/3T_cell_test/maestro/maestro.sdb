ADE simulation setup
Run mode: Single Run, Sweeps and Corners
Tests:
  eDRAMLib_3T_cell_test_1: eDRAMLib/3T_cell_test/schematic, simulator spectre
    Variables: t = 2n
    Outputs: /I0/sn
