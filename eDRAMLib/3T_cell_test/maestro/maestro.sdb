ADE simulation setup
Run mode: Single Run, Sweeps and Corners
Tests:
  eDRAMLib_3T_cell_test_1: eDRAMLib/3T_cell_test/schematic, simulator spectre
    Variables: t = 2n; B0 = 0xEF; B1 = 0xBE; B2 = 0xAD; B3 = 0xDE
    Outputs: /rbl_out<31:0>
