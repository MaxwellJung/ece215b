ADE simulation setup
Test final_project_3X8_Decoder_1: final_project/3X8_Decoder/schematic, simulator spectre
  Models: /w/apps4/public_libraries/tech/cadence/cadence/45nm/gpdk045_v_3_5/gpdk045/../models/spectre/gpdk045.scs[mc]
  Variables: i1 = 0; i1_b = 1; i2 = 0; i2_b = 1; i3 = 1; i3_b = 0
  Temperature: 27
  Analysis tran: stop=1u errpreset=conservative
  Signals: /i4, /i5, /i6, /y0, /y1, /y2, /y3, /y4, /y5, /y6, /y7
Run mode: Single Run, Sweeps and Corners
