ADE simulation setup
Run mode: Single Run, Sweeps and Corners
Tests:
  eDRAMLib_sense_amp_32_test_1: eDRAMLib/sense_amp_32_test/schematic, simulator spectre
    Variables: midpoint = 0.5; vd = 1
    Outputs: "/I44/wbl_b<31>"; /I44/wbl_b<31>; "/wbl\\"; "/I44/wbl<31>"; "/I44/j_wbl_i<31>"; "/wbl"; /wbl
