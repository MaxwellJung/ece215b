ADE simulation setup
Test eDRAMLib_sense_amp_32_test_1: eDRAMLib/sense_amp_32_test/schematic, simulator spectre
  Models: /w/apps4/public_libraries/tech/cadence/cadence/45nm/gpdk045_v_3_5/gpdk045/../models/spectre/gpdk045.scs[tt]
  Variables: midpoint = 0.5; vd = 1
  Temperature: 27
  Analysis tran: stop=16n errpreset=conservative
  Signals: /wwl, /rwl, /wbl, /I44/I0<31>/sn, /I44/wbl_b_i<31>, /I44/wbl_b<31>, /I44/I4<31>/sn, /rbl_p<31>, /rbl, /rbl_b_p<31>, /rbl_b, /sense_en, /out, /out_b
Run mode: Single Run, Sweeps and Corners
