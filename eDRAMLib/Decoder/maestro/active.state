ADE simulation setup
Test final_project_Decoder_1: eDRAMLib/Decoder/schematic, simulator spectre
  Models: /w/apps4/public_libraries/tech/cadence/cadence/45nm/gpdk045_v_3_5/gpdk045/../models/spectre/gpdk045.scs[mc]
  Variables: i0 = 1; i0_b = 0; i1 = 1; i1_b = 0; i2 = 0; i2_b = 1; i3 = 1; i3_b = 0; i4 = 0; i4_b = 1; i5 = 1; i5_b = 0; i6 = 1; i6_b = 0
  Temperature: 27
  Analysis tran: stop=10n errpreset=conservative
  Signals: /S_I0, /S_I1, /S_I2, /S_I3, /S_I4, /S_I5, /S_I6, /S_WL_0, /S_WL_4, /S_WL_20, /EN_0, /EN_1, /EN_2, /EN_3, /EN_4, /EN_5, /EN_6, /EN_7
Run mode: Single Run, Sweeps and Corners
Setup values for test final_project_Decoder_1: i4 = 1; i4_b = 0; i6 = 0; i6_b = 1
