ADE simulation setup
Run mode: Single Run, Sweeps and Corners
Tests:
  final_project_Decoder_1: final_project/Decoder/schematic, simulator spectre
    Variables: i0 = 1; i0_b = 0; i1 = 1; i1_b = 0; i2 = 0; i2_b = 1; i3 = 1; i3_b = 0; i4 = 1; i4_b = 0; i5 = 1; i5_b = 0; i6 = 0; i6_b = 1
