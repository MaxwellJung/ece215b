ADE simulation setup
Test eDRAMLib_eDRAM_test_1: eDRAMLib/eDRAM_test/schematic, simulator spectre
  Models: /w/apps4/public_libraries/tech/cadence/cadence/45nm/gpdk045_v_3_5/gpdk045/../models/spectre/gpdk045.scs[tt]
  Variables: aB0 = 6; aB1 = 0; dB0 = 0; dB1 = 0; dB2 = 255; dB3 = 255; t = 2n
  Temperature: 27
  Analysis tran: stop=5n errpreset=liberal
  Signals: /ReadEn, /I0/rbl2<31:0>, /I0/rbl<31:0>, /I0/rbl_b2<31:0>, /I0/rbl_b<31:0>, /I0/AmpEn, /I0/rbl_amp<31:0>, /I0/rbl<31>, /I0/net11<31>, /I0/rbl_b<31>, /I0/rbl_amp<31>
Run mode: Single Run, Sweeps and Corners
Setup values for test eDRAMLib_eDRAM_test_1: dB1 = 255; dB2 = 0
