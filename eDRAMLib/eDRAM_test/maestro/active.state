ADE simulation setup
Test eDRAMLib_eDRAM_test_1: eDRAMLib/eDRAM_test/schematic, simulator spectre
  Models: /w/apps4/public_libraries/tech/cadence/cadence/45nm/gpdk045_v_3_5/gpdk045/../models/spectre/gpdk045.scs[tt]
  Variables: aB0 = 6; aB1 = 0; dB0 = 0; dB1 = 255; dB2 = 0; dB3 = 255; t = 2n
  Temperature: 27
  Analysis tran: stop=200p errpreset=conservative
  Signals: /Addr<8:0>, /ReadEn, /WriteEn, /I0/WL<127:96>, /I0/WL<63:32>, /I0/WL<95:64>, /I0/WL<31:0>, /I0/Col3, /I0/Col2, /I0/Col1, /I0/Col0, /I0/rbl3<31:0>, /I0/rbl2<31:0>, /I0/rbl1<31:0>, /I0/rbl0<31:0>, /I0/wbl<31:0>, /I0/rbl<31:0>, /I0/rbl_amp<31:0>, /DQ<31:0>, /dbyte3<7>, /dbyte3<6>, /dbyte3<5>, /dbyte3<4>, /dbyte3<3>, /dbyte3<2>, /dbyte3<1>, /dbyte3<0>, /dbyte2<7>, /dbyte2<6>, /dbyte2<5>, /dbyte2<4>, /dbyte2<3>, /dbyte2<2>, /dbyte2<1>, /dbyte2<0>, /dbyte1<7>, /dbyte1<6>, /dbyte1<5>, /dbyte1<4>, /dbyte1<3>, /dbyte1<2>, /dbyte1<1>, /dbyte1<0>, /dbyte0<7>, /dbyte0<6>, /dbyte0<5>, /dbyte0<4>, /dbyte0<3>, /dbyte0<2>, /dbyte0<1>, /dbyte0<0>, /testWord<31:0>
Run mode: Single Run, Sweeps and Corners
