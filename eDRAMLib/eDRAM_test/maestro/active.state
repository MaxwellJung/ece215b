ADE simulation setup
Test eDRAMLib_eDRAM_test_1: eDRAMLib/eDRAM_test/schematic, simulator spectre
  Models: /w/apps4/public_libraries/tech/cadence/cadence/45nm/gpdk045_v_3_5/gpdk045/../models/spectre/gpdk045.scs[tt]
  Variables: aB0 = 6; aB1 = 0; dB0 = 0xEF; dB1 = 0xCD; dB2 = 0xAB; dB3 = 0x89; t = 2n
  Temperature: 27
  Analysis tran: stop=10n errpreset=conservative
  Signals: /Addr<8:0>, /ReadEn, /WriteEn, /I0/WL<127:96>, /I0/WL<63:32>, /I0/WL<95:64>, /I0/WL<31:0>, /I0/Col3, /I0/Col2, /I0/Col1, /I0/Col0, /I0/rbl3<31:0>, /I0/rbl2<31:0>, /I0/rbl1<31:0>, /I0/rbl0<31:0>, /I0/wbl<31:0>, /I0/rbl<31:0>, /I0/rbl_amp<31:0>, /DQ<31:0>
Run mode: Single Run, Sweeps and Corners
Setup values for test eDRAMLib_eDRAM_test_1: dB0 = 0; dB1 = 255; dB2 = 0; dB3 = 255
