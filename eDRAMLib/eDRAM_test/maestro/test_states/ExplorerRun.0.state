ADE simulation setup
Test eDRAMLib_eDRAM_test_1: eDRAMLib/eDRAM_test/schematic, simulator spectre
  Models: /w/apps4/public_libraries/tech/cadence/cadence/45nm/gpdk045_v_3_5/gpdk045/../models/spectre/gpdk045.scs[mc]
  Temperature: 27
