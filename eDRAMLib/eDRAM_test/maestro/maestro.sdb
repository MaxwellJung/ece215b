ADE simulation setup
Run mode: Single Run, Sweeps and Corners
Tests:
  eDRAMLib_eDRAM_test_1: eDRAMLib/eDRAM_test/schematic, simulator spectre
    Variables: aB0 = 6; aB1 = 0; dB0 = 0; dB1 = 0; dB2 = 255; dB3 = 255; t = 2n
    Outputs: "/I0/amp_out<31:0>"; /I0/WL<127:0>; "/I0/amp_out_b<31>"; /I0/amp_out<31:0>; "/I0/amp_out<3>"; "/X"; /X; "/I0/amp_out_b<0>"; "/I0/amp_out_b<31:0>"; "/I0/amp_out<31>"; /I0/amp_out_b<31:0>
