ADE simulation setup
Run mode: Single Run, Sweeps and Corners
Tests:
  eDRAMLib_eDRAM_test_1: eDRAMLib/eDRAM_test/schematic, simulator spectre
    Variables: aB0 = 6; aB1 = 0; dB0 = 0xEF; dB1 = 0xCD; dB2 = 0xAB; dB3 = 0x89; t = 2n
    Outputs: /I0/rbl_amp<31:0>
