ADE simulation setup
Test eDRAMLib_simple_test_1: eDRAMLib/simple_test/schematic, simulator spectre
  Models: /w/apps4/public_libraries/tech/cadence/cadence/45nm/gpdk045_v_3_5/gpdk045/../models/spectre/gpdk045.scs[tt]
  Variables: aB0 = 0; aB1 = 0; dB0 = 10; dB1 = 10; dB2 = 10; dB3 = 10; t = 4n
  Temperature: 25
  Analysis tran: stop=10n errpreset=moderate
  Signals: /I0/Col3, /I0/Col2, /I0/Col1, /I0/Col0, /ReadEn, /I0/rbl<31:0>, /I0/rbl_b<31:0>, /I0/AmpEn, /I0/rbl_amp<31:0>, /DQ<31:0>, /I0/rbl<31>, /I0/rbl_b<31>, /I0/rbl_amp<31>, /I0/net9
Run mode: Single Run, Sweeps and Corners
Setup values for test eDRAMLib_simple_test_1: aB0 = 15; aB1 = 15; t = 8n
