ADE simulation setup
Run mode: Single Run, Sweeps and Corners
Tests:
  eDRAMLib_simple_test_1: eDRAMLib/simple_test/schematic, simulator spectre
    Variables: aB0 = 15; aB1 = 15; dB0 = 10; dB1 = 10; dB2 = 10; dB3 = 10; t = 8n
    Outputs: "/I0/wbl"; "/I0/net17<31:0>"; "/I0/net9"; /I0/net9
